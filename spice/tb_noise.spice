* Integrated output-referred noise (onoise_total is RMS in volts)
.lib "PDK_ROOT/sky130A/libs.tech/ngspice/sky130.lib.spice" tt
.include "vbuffer.spice"
Vdd vdd 0 1.8
Vin vinp 0 dc 0.6 ac 1
Xbuf vdd 0 vinp vout vout vbuffer
CLd vout 0 5p
.control
op
noise v(vout) Vin dec 100 1 1e9 1
print onoise_total
.endc
.end
